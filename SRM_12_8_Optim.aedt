# Ansys Electronics Desktop project, version 2018.0
materials:
  M19_24G: permeability{BType=normal HUnit=A_per_meter BUnit=tesla curve (0, 0) (22.28, 0.05) (25.46, 0.1) (31.83, 0.15) (47.74, 0.36) (63.66, 0.54) (79.57, 0.65) (159.15, 0.99) (318.3, 1.2) (477.46, 1.28) (636.61, 1.33) (795.77, 1.36) (1591.5, 1.44) (3183, 1.52) (4774.6, 1.58) (6366.1, 1.63) (7957.7, 1.67) (15915, 1.8) (31830, 1.9) (111407, 2) (190984, 2.1) (350138, 2.3) (509292, 2.5)} conductivity=1960000 core_loss_type="Electrical Steel" core_loss_kh=164.2 core_loss_kc=1.3 core_loss_ke=1.72 mass_density=7650
  copper: permeability=0.999991 conductivity=58000000
  vacuum: permittivity=1

design oMaxwell2DDesig_Conditional1 (Maxwell 2D, Transient, XY geometry, model units mm)
options: ComputeTransientInductance ComputeIncrementalMatrix ModelDepth=1meter Multiplier=1
variables:
  RotorOuterRadius = 49.6mm
  RotorYoke = 15mm
  RotorPoleArcByPolePitch = 0.4
  StatorOuterRadius = 80mm
  gap = 0.25mm
  StatorYoke = 10mm
  StatorPoleArcByPolePitch = 0.5
  ThetaR = 0deg
  I_a = (ThetaR>=ThI && ThetaR<=Thf)*500
  I_b = 0A
  I_c = 0A
  param = 0
  ThI = 18deg
  Thf = 38deg
  I_aa = 44A
  Nc = 5
  Spdr = 2500rpm
  time_pole = pi/4/Spdr/pi*30*1rpm s
datasets:
  ds1: (0, 0) (1, 0) (2, 0) (3, 0) (4, 0) (5, 0) (6, 0) (7, 0) (8, 0) (9, 0) (10, 0) (11, 0) (12, 0) (13, 0) (14, 0) (15, 0) (16, 0) (17, 0) (17.9, 0) (18, 500) (19, 500) (20, 500) (21, 500) (22, 500) (23, 500) (24, 500) (25, 500) (26, 500) (27, 500) (28, 500) (29, 500) (30, 500) (31, 500) (32, 500) (33, 500) (34, 500) (35, 500) (36, 500) (37, 500) (38, 500) (38.1, 0) (39, 0) (40, 0) (41, 0) (42, 0) (43, 0) (44, 0)
geometry:
  SRMCore1 [M19_24G] = user_primitive(RMxprt/SRMCore.dll, DiaGap=RotorOuterRadius*2, DiaYoke=(RotorOuterRadius-RotorYoke-20mm)*2, Length=0mm, Poles=8, ThkYoke=RotorYoke, Embrace=RotorPoleArcByPolePitch, EndExt=5mm, LenRegion=200mm, InfoCore=0)
  SRMCore2 [M19_24G] = user_primitive(RMxprt/SRMCore.dll, DiaGap=(RotorOuterRadius+gap)*2, DiaYoke=StatorOuterRadius*2, Length=0mm, Poles=12, ThkYoke=StatorYoke, Embrace=StatorPoleArcByPolePitch, EndExt=5mm, LenRegion=200mm, InfoCore=0)
  Circle1 [vacuum] = circle(normal=Z, centre=(0mm, 0mm, 0mm), radius=StatorOuterRadius)
  SRMCore3 [copper] = user_primitive(RMxprt/SRMCore.dll, DiaGap=(RotorOuterRadius+gap)*2, DiaYoke=StatorOuterRadius*2, Length=0mm, Poles=12, ThkYoke=StatorYoke, Embrace=StatorPoleArcByPolePitch, EndExt=5mm, LenRegion=200mm, InfoCore=3)
  SRMCore4 [copper] = user_primitive(RMxprt/SRMCore.dll, DiaGap=(RotorOuterRadius+gap)*2, DiaYoke=StatorOuterRadius*2, Length=0mm, Poles=12, ThkYoke=StatorYoke, Embrace=StatorPoleArcByPolePitch, EndExt=5mm, LenRegion=200mm, InfoCore=4)
  SRMCore4_1..SRMCore4_11 [copper] = SRMCore4.duplicate_around_axis(axis=Z, angle=30deg, total=12)
  SRMCore3_1..SRMCore3_11 [copper] = SRMCore3.duplicate_around_axis(axis=Z, angle=30deg, total=12)
  SRMCore1.rotate(axis=Z, angle=ThetaR)
  Circle2 [vacuum] = circle(normal=Z, centre=(0mm, 0mm, 0mm), radius=RotorOuterRadius+0.1mm)
  coordinate_system RelativeCS1 = origin=(0mm, 0mm, 0mm) x=(135.57415mm, 36.326984mm, 0mm) y=(-36.326984mm, 135.57415mm, 0mm)
motion:
  MotionSetup1: Band Move_Type=Rotate Coordinate_System=Global Axis=Z Is_Positive=true InitPos=10deg Angular_Velocity=Spdr Objects=Circle2
  Moving1: Moving Objects=SRMCore1
boundaries and excitations:
  VectorPotential1: Vector Potential Edges=Circle1.edge(1 of 1) Value=0
  A_1: Coil Objects=SRMCore3 Conductor_number=Nc Winding=A PolarityType=Positive
  A_2: Coil Objects=SRMCore4 Conductor_number=Nc Winding=A PolarityType=Negative
  A_3: Coil Objects=SRMCore3_3 Conductor_number=Nc Winding=A PolarityType=Positive
  A_4: Coil Objects=SRMCore4_3 Conductor_number=Nc Winding=A PolarityType=Negative
  A_5: Coil Objects=SRMCore3_6 Conductor_number=Nc Winding=A PolarityType=Positive
  A_6: Coil Objects=SRMCore4_6 Conductor_number=Nc Winding=A PolarityType=Negative
  A_7: Coil Objects=SRMCore3_9 Conductor_number=Nc Winding=A PolarityType=Positive
  A_8: Coil Objects=SRMCore4_9 Conductor_number=Nc Winding=A PolarityType=Negative
  A: Winding Group Type=Current IsSolid=false Current=I_aa ParallelBranchesNum=4
parameters:
  Torque1: Torque Coordinate_System=Global Is_Positive=true Objects=SRMCore1
mesh:
  initial mesh: MeshMethod=AnsoftTAU
setups:
  Setup1: Transient NonlinearSolverResidual=0.0001 StopTime=time_pole TimeStep=time_pole/50 SweepSetupType=LinearStep StartValue=0ns StopValue=0.006s StepSize=0.00012s InitialTimeStep=0.002s MinTimeStep=0.001s MaxTimeStep=0.003s TimeStepErrTolerance=0.0001
optimetrics:
  ParametricSetup1: Parametric
    sweep ThetaR: LIN 0deg 45deg 1deg
  ParametricSetup2: Parametric
    sweep RotorOuterRadius: LIN 50mm 90mm 10mm
  ParametricSetup4: Parametric
    sweep param: LIN 0 45 1 LIN 0 180 3
  Iaa: Parametric Sim._Setups=[Setup1]
    sweep I_aa: LINC 0A 440A 11
  Ia_Nc: Parametric Sim._Setups=[Setup1]
    sweep Nc: LIN 20 100 20
reports:
  FluxLinkage: FluxLinkage(A) vs Moving1.Position, I_aa on Setup1 : Transient [ThetaR=0deg param=0 RotorOuterRadius=49.6mm Nc=10]
  Torque: Moving1.Torque vs Moving1.Position, I_aa on Setup1 : Transient [ThetaR=0deg param=0 RotorOuterRadius=49.6mm Nc=10]
  Torque Plot 1: Moving1.Torque vs Moving1.Position on Setup1 : Transient [RotorOuterRadius=all ThetaR=all param=all I_aa=all Nc=all]
  Winding Plot 1: FluxLinkage(A) vs Time on Setup1 : Transient [RotorOuterRadius=all ThetaR=all param=all I_aa=all Nc=all]
  Winding Plot 2: L(A,A) vs Time on Setup1 : Transient [RotorOuterRadius=all ThetaR=all param=all I_aa=all Nc=all]
  FluxLinkage1: FluxLinkage(A) vs Moving1.Position, I_aa on Setup1 : Transient [ThetaR=0deg param=0 RotorOuterRadius=49.6mm Nc=10]
  Torque1: Moving1.Torque vs Moving1.Position, I_aa on Setup1 : Transient [ThetaR=0deg param=0 RotorOuterRadius=49.6mm Nc=10]
